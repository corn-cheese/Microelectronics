* SKY130 BJT 1-stage AC sanity check
.include "C:/eda/sky130/skywater-pdk-libs-sky130_fd_pr/models/corners/tt/nonfet.spice"
.include "C:/eda/sky130/skywater-pdk-libs-sky130_fd_pr/cells/npn_05v5/sky130_fd_pr__npn_05v5__t.corner.spice"

.option klu
.option reltol=1e-4

.param VDD=5
.param VCM=2.5

VDD vdd 0 {VDD}
VIN vin 0 DC {VCM} AC 1

* Reuse the verified bjt1_op bias point; drive the base through AC coupling.
CIN1 vin b1_base 1u
RB1_TOP vdd b1_base 330k
RB1_BOT b1_base 0 100k
RC1 vdd b1_collector 100k
RE1 b1_emitter 0 20k

* SKY130 npn_05v5 is exposed as a 4-pin subckt: c b e s.
XQ1 b1_collector b1_base b1_emitter 0 sky130_fd_pr__npn_05v5_W1p00L1p00 mult=1

* Keep the planned output node name available for reports.
VOUT_ALIAS b1_out b1_collector 0
RLOAD_AC b1_out 0 1G

.control
set noaskquit
set wr_singlescale
set wr_vecnames
op
ac dec 50 1 1Meg
let gain = v(b1_out)/v(vin)
let gain_vv = mag(gain)
let gain_db = db(gain)
let phase_deg = ph(gain)
meas ac midgain_vv find gain_vv at=1000
meas ac midgain_db find gain_db at=1000
meas ac phase_1k_deg find phase_deg at=1000
wrdata D:/Codex/Support/results/ngspice/csv/bjt1_ac.csv gain_vv gain_db phase_deg
write D:/Codex/Support/results/ngspice/raw/bjt1_ac.raw frequency v(vin) v(b1_base) v(b1_emitter) v(b1_collector) v(b1_out) gain gain_vv gain_db phase_deg
quit
.endc

.end
