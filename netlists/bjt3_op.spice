* SKY130 BJT 3-stage DC operating point sanity check
.include "C:/eda/sky130/skywater-pdk-libs-sky130_fd_pr/models/corners/tt/nonfet.spice"
.include "C:/eda/sky130/skywater-pdk-libs-sky130_fd_pr/cells/npn_05v5/sky130_fd_pr__npn_05v5__t.corner.spice"

.option savecurrents
.option klu
.option reltol=1e-4

.param VDD=5

VDD vdd 0 {VDD}

RB1_TOP vdd b1_base 330k
RB1_BOT b1_base 0 100k
RC1 vdd b1_collector 100k
RE1 b1_emitter 0 20k
XQ1 b1_collector b1_base b1_emitter 0 sky130_fd_pr__npn_05v5_W1p00L1p00 mult=1

C12 b1_collector b2_base 1u

RB2_TOP vdd b2_base 330k
RB2_BOT b2_base 0 100k
RC2 vdd b2_collector 100k
RE2 b2_emitter 0 20k
XQ2 b2_collector b2_base b2_emitter 0 sky130_fd_pr__npn_05v5_W1p00L1p00 mult=1

C23 b2_collector b3_base 1u

RB3_TOP vdd b3_base 330k
RB3_BOT b3_base 0 100k
RC3 vdd b3_collector 100k
RE3 b3_emitter 0 20k
XQ3 b3_collector b3_base b3_emitter 0 sky130_fd_pr__npn_05v5_W1p00L1p00 mult=1

VOUT_ALIAS vout_final b3_collector 0
RLOAD_OP vout_final 0 1G

.control
set noaskquit
op
print v(vdd)
print v(b1_base) v(b1_emitter) v(b1_collector)
print v(b2_base) v(b2_emitter) v(b2_collector)
print v(b3_base) v(b3_emitter) v(b3_collector) v(vout_final)
print v(b1_base)-v(b1_emitter) v(b1_collector)-v(b1_emitter)
print v(b2_base)-v(b2_emitter) v(b2_collector)-v(b2_emitter)
print v(b3_base)-v(b3_emitter) v(b3_collector)-v(b3_emitter)
print v(b1_collector)-v(b2_base)
print v(b2_collector)-v(b3_base)
print i(vdd)
write D:/Codex/Support/results/ngspice/raw/bjt3_op.raw
quit
.endc

.end
