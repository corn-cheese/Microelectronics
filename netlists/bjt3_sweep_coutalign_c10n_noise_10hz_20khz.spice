* SKY130 BJT 3-stage COUT pole-alignment target-band noise check: COUT=10n, ROUT=10Meg/10Meg
.include "C:/eda/sky130/skywater-pdk-libs-sky130_fd_pr/models/corners/tt/nonfet.spice"
.include "C:/eda/sky130/skywater-pdk-libs-sky130_fd_pr/cells/npn_05v5/sky130_fd_pr__npn_05v5__t.corner.spice"

.option savecurrents
.option sparse
.option reltol=1e-4

.param VDD=5
.param VCM=2.5
.param CCPL=68n
.param CH=30p
.param RCVAL=120k
.param REVAL=18.5k
.param COUT=10n
.param ROUT=10Meg

VDD vdd 0 {VDD}
VIN vin 0 DC {VCM} AC 1

.include "D:/Codex/Support/netlists/bjt3_sweep_rebias_core.inc"

.control
set noaskquit
set wr_singlescale
set wr_vecnames
op
noise v(vout_final) VIN dec 80 10 20k
setplot noise1
wrdata D:/Codex/Support/results/ngspice/csv/bjt3_sweep_coutalign_c10n_noise_10hz_20khz.csv onoise_spectrum inoise_spectrum
write D:/Codex/Support/results/ngspice/raw/bjt3_sweep_coutalign_c10n_noise_10hz_20khz.raw frequency onoise_spectrum inoise_spectrum
setplot noise2
print onoise_total inoise_total
wrdata D:/Codex/Support/results/ngspice/csv/bjt3_sweep_coutalign_c10n_noise_10hz_20khz_total.csv onoise_total inoise_total
quit
.endc

.end
