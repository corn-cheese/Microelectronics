* SKY130 BJT 3-stage high-frequency fourth-pole tran: CHOUT=47p
.include "C:/eda/sky130/skywater-pdk-libs-sky130_fd_pr/models/corners/tt/nonfet.spice"
.include "C:/eda/sky130/skywater-pdk-libs-sky130_fd_pr/cells/npn_05v5/sky130_fd_pr__npn_05v5__t.corner.spice"

.option savecurrents
.option klu
.option reltol=1e-4

.param VDD=5
.param VCM=2.5
.param VIN_AMP=1m
.param FIN=1k
.param CCPL=68n
.param CH=30p
.param CHOUT=47p
.param RCVAL=120k
.param REVAL=18.5k
.param COUT=10n
.param ROUT=10Meg

VDD vdd 0 {VDD}
VIN vin 0 SIN({VCM} {VIN_AMP} {FIN})

.include "D:/Codex/Support/netlists/bjt3_sweep_rebias_core.inc"

* Intentional fourth high-frequency pole candidate. CLOAD_10P remains the external evaluation load.
CHF4 vout_final 0 {CHOUT}

.control
set noaskquit
set wr_singlescale
set wr_vecnames
op
tran 5u 100m 0 5u
meas tran out_max max v(vout_final) from=50m to=100m
meas tran out_min min v(vout_final) from=50m to=100m
meas tran vin_max max v(vin) from=50m to=100m
meas tran vin_min min v(vin) from=50m to=100m
wrdata D:/Codex/Support/results/ngspice/csv/bjt3_sweep_hf4pole_chout47p_tran.csv v(vin) v(b3_collector) v(vout_final) i(vdd)
write D:/Codex/Support/results/ngspice/raw/bjt3_sweep_hf4pole_chout47p_tran.raw
quit
.endc

.end
