* SKY130 BJT 3-stage transient response with 10 pF output load
.include "C:/eda/sky130/skywater-pdk-libs-sky130_fd_pr/models/corners/tt/nonfet.spice"
.include "C:/eda/sky130/skywater-pdk-libs-sky130_fd_pr/cells/npn_05v5/sky130_fd_pr__npn_05v5__t.corner.spice"

.option savecurrents
.option klu
.option reltol=1e-4

.param VDD=5
.param VCM=2.5
.param VIN_AMP=1m
.param FIN=1k

VDD vdd 0 {VDD}
VIN vin 0 SIN({VCM} {VIN_AMP} {FIN})

CIN vin b1_base 1u

RB1_TOP vdd b1_base 3.3Meg
RB1_BOT b1_base 0 1Meg
RC1 vdd b1_collector 120k
RE1 b1_emitter 0 20k
XQ1 b1_collector b1_base b1_emitter 0 sky130_fd_pr__npn_05v5_W1p00L1p00 mult=1

C12 b1_collector b2_base 1u

RB2_TOP vdd b2_base 3.3Meg
RB2_BOT b2_base 0 1Meg
RC2 vdd b2_collector 120k
RE2 b2_emitter 0 20k
XQ2 b2_collector b2_base b2_emitter 0 sky130_fd_pr__npn_05v5_W1p00L1p00 mult=1

C23 b2_collector b3_base 1u

RB3_TOP vdd b3_base 3.3Meg
RB3_BOT b3_base 0 1Meg
RC3 vdd b3_collector 120k
RE3 b3_emitter 0 20k
XQ3 b3_collector b3_base b3_emitter 0 sky130_fd_pr__npn_05v5_W1p00L1p00 mult=1

VOUT_ALIAS vout_final b3_collector 0
RLOAD_TRAN vout_final 0 1G
CLOAD_10P vout_final 0 10p

.control
set noaskquit
set wr_singlescale
set wr_vecnames
op
tran 1u 10m 0 1u
meas tran out_max max v(vout_final) from=5m to=10m
meas tran out_min min v(vout_final) from=5m to=10m
meas tran vin_max max v(vin) from=5m to=10m
meas tran vin_min min v(vin) from=5m to=10m
wrdata D:/Codex/Support/results/ngspice/csv/bjt3_load10p_tran.csv v(vin) v(b1_base) v(b1_collector) v(b2_collector) v(b3_collector) v(vout_final) i(vdd)
write D:/Codex/Support/results/ngspice/raw/bjt3_load10p_tran.raw
quit
.endc

.end
