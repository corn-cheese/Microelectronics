* SKY130 BJT 3-stage unloaded AC response
.include "C:/eda/sky130/skywater-pdk-libs-sky130_fd_pr/models/corners/tt/nonfet.spice"
.include "C:/eda/sky130/skywater-pdk-libs-sky130_fd_pr/cells/npn_05v5/sky130_fd_pr__npn_05v5__t.corner.spice"

.option savecurrents
.option klu
.option reltol=1e-4

.param VDD=5
.param VCM=2.5

VDD vdd 0 {VDD}
VIN vin 0 DC {VCM} AC 1

CIN vin b1_base 1u

RB1_TOP vdd b1_base 3.3Meg
RB1_BOT b1_base 0 1Meg
RC1 vdd b1_collector 120k
RE1 b1_emitter 0 20k
XQ1 b1_collector b1_base b1_emitter 0 sky130_fd_pr__npn_05v5_W1p00L1p00 mult=1

C12 b1_collector b2_base 1u

RB2_TOP vdd b2_base 3.3Meg
RB2_BOT b2_base 0 1Meg
RC2 vdd b2_collector 120k
RE2 b2_emitter 0 20k
XQ2 b2_collector b2_base b2_emitter 0 sky130_fd_pr__npn_05v5_W1p00L1p00 mult=1

C23 b2_collector b3_base 1u

RB3_TOP vdd b3_base 3.3Meg
RB3_BOT b3_base 0 1Meg
RC3 vdd b3_collector 120k
RE3 b3_emitter 0 20k
XQ3 b3_collector b3_base b3_emitter 0 sky130_fd_pr__npn_05v5_W1p00L1p00 mult=1

VOUT_ALIAS vout_final b3_collector 0
RLOAD_AC vout_final 0 1G

.control
set noaskquit
set wr_singlescale
set wr_vecnames
op
ac dec 50 1 1Meg
let gain = v(vout_final)/v(vin)
let gain_vv = mag(gain)
let gain_db = db(gain)
let phase_deg = ph(gain)
meas ac midgain_vv find gain_vv at=1000
meas ac midgain_db find gain_db at=1000
meas ac phase_1k_deg find phase_deg at=1000
wrdata D:/Codex/Support/results/ngspice/csv/bjt3_ac.csv gain_vv gain_db phase_deg
write D:/Codex/Support/results/ngspice/raw/bjt3_ac.raw frequency v(vin) v(b1_base) v(b1_collector) v(b2_collector) v(b3_collector) v(vout_final) gain gain_vv gain_db phase_deg
quit
.endc

.end
