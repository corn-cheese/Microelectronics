* SKY130 BJT 2-stage PPA sweep noise: CE1 -> CE2 -> output rebias -> ideal OPAMP follower -> two RC poles
.include "C:/eda/sky130/skywater-pdk-libs-sky130_fd_pr/models/corners/tt/nonfet.spice"
.include "C:/eda/sky130/skywater-pdk-libs-sky130_fd_pr/cells/npn_05v5/sky130_fd_pr__npn_05v5__t.corner.spice"

.option savecurrents
.option sparse
.option reltol=1e-4

.param VDD=5
.param VCM=2.5
.param RB_TOP=4.7Meg
.param RB_BOT=1Meg
.param RCVAL=120k
.param REVAL=3.9k
.param CCPL=68n
.param C12A=33n
.param C12B=33n
.param RLF=22Meg
.param COUT=10n
.param CH=24p
.param ROUT=10Meg
.param RBUF=12k
.param CBUF=180p
.param OPAMP_FT=250k
.param IOPAMP={OPAMP_FT*7e-12}
.param pi=3.141592653589793
.param ROPAMP=1k
.param COPAMP={1/(2*pi*ROPAMP*OPAMP_FT)}

VDD vdd 0 {VDD}
VIN vin 0 DC {VCM} AC 1

CIN vin b1_base {CCPL}

RB1_TOP vdd b1_base {RB_TOP}
RB1_BOT b1_base 0 {RB_BOT}
RC1 vdd b1_collector {RCVAL}
RE1 b1_emitter 0 {REVAL}
XQ1 b1_collector b1_base b1_emitter 0 sky130_fd_pr__npn_05v5_W1p00L1p00 mult=1
CH1 b1_collector 0 {CH}

C12A b1_collector vlf_mid {C12A}
RLF_TOP vdd vlf_mid {RLF}
RLF_BOT vlf_mid 0 {RLF}
C12B vlf_mid b2_base {C12B}

RB2_TOP vdd b2_base {RB_TOP}
RB2_BOT b2_base 0 {RB_BOT}
RC2 vdd b2_collector {RCVAL}
RE2 b2_emitter 0 {REVAL}
XQ2 b2_collector b2_base b2_emitter 0 sky130_fd_pr__npn_05v5_W1p00L1p00 mult=1
CH2 b2_collector 0 {CH}

COUT b2_collector vout_drv {COUT}
ROUT_TOP vdd vout_drv {ROUT}
ROUT_BOT vout_drv 0 {ROUT}
EBUF vop_ideal 0 vout_drv 0 1
ROPAMP vop_ideal vbuf {ROPAMP}
COPAMP vbuf 0 {COPAMP}
IOPAMP vdd 0 {IOPAMP}
RBUF1 vbuf vfilt1 {RBUF}
CBUF1 vfilt1 0 {CBUF}
RBUF2 vfilt1 vout_final {RBUF}
CBUF2 vout_final 0 {CBUF}
CLOAD_10P vout_final 0 10p

.control
set noaskquit
set wr_singlescale
set wr_vecnames
op
noise v(vout_final) VIN dec 80 10 20k
setplot noise1
wrdata D:/Codex/Support/Microelectronics-2stage-autotopo-ppa/results/ngspice/csv/bjt2_autotopo_ilf_rc120k_re3p9k_rb4p7m_cin68n_c12a33n_c12b33n_rlf22m_cout10n_ch24p_r12k_c180p_ft250k_noise_10hz_20khz.csv onoise_spectrum inoise_spectrum
write D:/Codex/Support/Microelectronics-2stage-autotopo-ppa/results/ngspice/raw/bjt2_autotopo_ilf_rc120k_re3p9k_rb4p7m_cin68n_c12a33n_c12b33n_rlf22m_cout10n_ch24p_r12k_c180p_ft250k_noise_10hz_20khz.raw frequency onoise_spectrum inoise_spectrum
setplot noise2
print onoise_total inoise_total
wrdata D:/Codex/Support/Microelectronics-2stage-autotopo-ppa/results/ngspice/csv/bjt2_autotopo_ilf_rc120k_re3p9k_rb4p7m_cin68n_c12a33n_c12b33n_rlf22m_cout10n_ch24p_r12k_c180p_ft250k_noise_10hz_20khz_total.csv onoise_total inoise_total
quit
.endc

.end
