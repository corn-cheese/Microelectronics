* SKY130 BJT 3-stage high-cutoff sweep noise candidate: CH=30p
.include "C:/eda/sky130/skywater-pdk-libs-sky130_fd_pr/models/corners/tt/nonfet.spice"
.include "C:/eda/sky130/skywater-pdk-libs-sky130_fd_pr/cells/npn_05v5/sky130_fd_pr__npn_05v5__t.corner.spice"

.option savecurrents
.option sparse
.option reltol=1e-4

.param VDD=5
.param VCM=2.5
.param CH=30p

VDD vdd 0 {VDD}
VIN vin 0 DC {VCM} AC 1

.include "D:/Codex/Support/netlists/bjt3_sweep_highcut_core.inc"

.control
set noaskquit
set wr_singlescale
set wr_vecnames
op
noise v(vout_final) VIN dec 80 1 1Meg
setplot noise1
display
wrdata D:/Codex/Support/results/ngspice/csv/bjt3_sweep_highcut_ch30p_noise.csv onoise_spectrum inoise_spectrum
write D:/Codex/Support/results/ngspice/raw/bjt3_sweep_highcut_ch30p_noise.raw frequency onoise_spectrum inoise_spectrum
setplot noise2
print onoise_total inoise_total
wrdata D:/Codex/Support/results/ngspice/csv/bjt3_sweep_highcut_ch30p_noise_total.csv onoise_total inoise_total
quit
.endc

.end
