* SKY130 BJT 1-stage DC operating point sanity check
.include "C:/eda/sky130/skywater-pdk-libs-sky130_fd_pr/models/corners/tt/nonfet.spice"
.include "C:/eda/sky130/skywater-pdk-libs-sky130_fd_pr/cells/npn_05v5/sky130_fd_pr__npn_05v5__t.corner.spice"

.option savecurrents
.option klu
.option reltol=1e-4

.param VDD=5

VDD vdd 0 {VDD}

* DC bias target: place the collector near mid-supply for a first OP sanity check.
RB1_TOP vdd b1_base 330k
RB1_BOT b1_base 0 100k
RC1 vdd b1_collector 100k
RE1 b1_emitter 0 20k

* SKY130 npn_05v5 is exposed as a 4-pin subckt: c b e s.
XQ1 b1_collector b1_base b1_emitter 0 sky130_fd_pr__npn_05v5_W1p00L1p00 mult=1

* Keep the planned output node name available for reports.
VOUT_ALIAS b1_out b1_collector 0
RLOAD_OP b1_out 0 1G

.control
set noaskquit
op
print v(vdd) v(b1_base) v(b1_emitter) v(b1_collector) v(b1_out)
print v(b1_base)-v(b1_emitter) v(b1_collector)-v(b1_emitter)
print i(vdd)
write D:/Codex/Support/results/ngspice/raw/bjt1_op.raw
quit
.endc

.end
