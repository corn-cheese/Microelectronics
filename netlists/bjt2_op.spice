* SKY130 BJT 2-stage DC operating point sanity check
.include "C:/eda/sky130/skywater-pdk-libs-sky130_fd_pr/models/corners/tt/nonfet.spice"
.include "C:/eda/sky130/skywater-pdk-libs-sky130_fd_pr/cells/npn_05v5/sky130_fd_pr__npn_05v5__t.corner.spice"

.option savecurrents
.option klu
.option reltol=1e-4

.param VDD=5

VDD vdd 0 {VDD}

* Stage 1 reuses the verified 1-stage bias point.
RB1_TOP vdd b1_base 330k
RB1_BOT b1_base 0 100k
RC1 vdd b1_collector 100k
RE1 b1_emitter 0 20k
XQ1 b1_collector b1_base b1_emitter 0 sky130_fd_pr__npn_05v5_W1p00L1p00 mult=1

* Interstage coupling blocks the stage 1 collector DC operating point.
CINT b1_collector b2_base 1u

* Stage 2 has an independent DC bias path.
RB2_TOP vdd b2_base 330k
RB2_BOT b2_base 0 100k
RC2 vdd b2_collector 100k
RE2 b2_emitter 0 20k
XQ2 b2_collector b2_base b2_emitter 0 sky130_fd_pr__npn_05v5_W1p00L1p00 mult=1

* Keep the planned final output node name available for reports.
VOUT_ALIAS vout_final b2_collector 0
RLOAD_OP vout_final 0 1G

.control
set noaskquit
op
print v(vdd)
print v(b1_base) v(b1_emitter) v(b1_collector)
print v(b2_base) v(b2_emitter) v(b2_collector) v(vout_final)
print v(b1_base)-v(b1_emitter) v(b1_collector)-v(b1_emitter)
print v(b2_base)-v(b2_emitter) v(b2_collector)-v(b2_emitter)
print v(b1_collector)-v(b2_base)
print i(vdd)
write D:/Codex/Support/Microelectronics-2stage/results/ngspice/raw/bjt2_op.raw
quit
.endc

.end
