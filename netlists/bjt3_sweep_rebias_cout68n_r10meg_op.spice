* SKY130 BJT 3-stage output rebias OP candidate: COUT=68n, ROUT=10Meg/10Meg
.include "C:/eda/sky130/skywater-pdk-libs-sky130_fd_pr/models/corners/tt/nonfet.spice"
.include "C:/eda/sky130/skywater-pdk-libs-sky130_fd_pr/cells/npn_05v5/sky130_fd_pr__npn_05v5__t.corner.spice"

.option savecurrents
.option klu
.option reltol=1e-4

.param VDD=5
.param VCM=2.5
.param CCPL=68n
.param CH=30p
.param RCVAL=120k
.param REVAL=18.5k
.param COUT=68n
.param ROUT=10Meg

VDD vdd 0 {VDD}
VIN vin 0 DC {VCM}

.include "D:/Codex/Support/netlists/bjt3_sweep_rebias_core.inc"

.control
set noaskquit
op
print v(vdd)
print v(b1_base) v(b1_emitter) v(b1_collector)
print v(b2_base) v(b2_emitter) v(b2_collector)
print v(b3_base) v(b3_emitter) v(b3_collector) v(vout_final)
print v(b1_base)-v(b1_emitter) v(b1_collector)-v(b1_emitter)
print v(b2_base)-v(b2_emitter) v(b2_collector)-v(b2_emitter)
print v(b3_base)-v(b3_emitter) v(b3_collector)-v(b3_emitter)
print i(vdd)
write D:/Codex/Support/results/ngspice/raw/bjt3_sweep_rebias_cout68n_r10meg_op.raw
quit
.endc

.end
